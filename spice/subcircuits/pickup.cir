* Wurlitzer 200A Electrostatic Pickup Model (current-source interface)
* ===================================================================
* Behavioral model of the variable-capacitance reed pickup, reduced to
* what the pickup physically is: a displacement-modulated capacitor on
* the plate node. It contains NO feed resistor and NO coupling cap.
*
* ---------------------------------------------------------------------
* REVISION 2026-09-22 (external circuit review): this subcircuit was
* pre-revision. It carried R_feed (1MEG vhv->plate) and C_coupling
* (0.022uF plate->sig_out), and quoted a 2312 Hz corner from a
* "R-2 2M to Vcc / R-3 470K to ground" input network. The 2026-09-13
* drawn-topology revision moved the input network INTO
* subcircuits/preamp.cir, which now owns R-2 (1MEG, the +150V
* polarizing rail treated as AC ground) and C-1 (0.022uF). Keeping them
* here as well instantiated both parts TWICE in every chain bench.
* Superseded, do not re-introduce: the 2312 Hz corner, the 287K
* R_feed||R_input network, R_feed/C_coupling in this subcircuit.
* ---------------------------------------------------------------------
*
* Revised topology (schematic #203720-S-3, docs/research/preamp-circuit.md
* §2.3):
*
*   +150V line -> R-2 (1M) -> R-1/C-1 junction -> R-1 (22K) -> plate
*
*   plate --[R-1 22K, external]-- preamp 'in' pin
*                                   |-- R-2 1MEG to AC ground  } inside
*                                   `-- C-1 0.022uF -> base1   } preamp.cir
*                                                 (C-2 220pF, R-3 470K ...)
*
* Why the polarizing voltage is an internal parameter:
*   A capacitive pickup draws no DC current, so there is no DC drop
*   across R-2 or R-1 and the plate sits at the full polarizing voltage.
*   The pickup's physics only needs that total bias V_pol; the signal
*   is the AC deviation V(plate) about it. Modelling the +150V rail as
*   AC ground (as preamp.cir's R2-to-gnd does) is then exactly right,
*   and V(plate) in this deck is an AC-only node at 0 V DC.
*
* Physics (REVISED 2026-09-25, overlap law — docs/research/pickup-overlap-law.md):
*   The 200A pickup is a through-slot comb. Each reed is a grounded steel
*   tine swinging between two fingers of the charged comb, across a small
*   side clearance, resting just outside the finger band (about a sheet of
*   paper, G0). Its capacitance
*   follows the reed-to-finger overlap, fringe-rounded at the band edges:
*   a field-solved law per keyboard section (subcircuits/pickup_law.inc,
*   GENERATED from the same tables the plugin runs). It is NOT the
*   parallel-plate C_0/(1-y) this deck used before; that geometry has no
*   plate facing the reed.
*     u     = SIGN * reed_disp - G0          (penetration past the near
*                                             finger face, mm)
*     C(u)  = C_0 * (1 + law(u) - law(-G0)) (= C_0 at rest)
*   Charge on that capacitance, with total plate voltage V_pol + V(plate):
*     Q = C(u) * (V_pol + V(plate))
*   The pickup draws i = dQ/dt from the plate node: a drive current
*   ~= V_pol * dC/dt plus the C(u)*dV(plate)/dt term that makes the reed
*   part of the plate capacitance. The law is the primary H2 ("bark")
*   source; it is one-sided (the reed enters the band on one half of its
*   swing only), so even harmonics dominate.
*
* Frequency response (set by the LOAD, not by this subcircuit):
*   C_total = C_0 + C_p = 240 pF (LOW confidence, pickup-system.md §3.6)
*   works against R-1 into the preamp input network (R-2 1M, C-1, C-2
*   220pF in parallel at audio, R-3 470K). Under the physical j*omega
*   drive the plate->R-1->preamp response is a high-pass with its
*   in-band corner at ~880-900 Hz (C-2 grounded). It is NOT one-pole:
*   the network is second-order-with-zero. Fit to the measured response,
*   not to a corner frequency. See docs/research/pickup-system.md §3.7.
*
* Key parameters:
*   C_0   = 3 pF    (per-reed capacitance at rest, estimated; also the
*                    scale of the law's normalised swing, as in the plugin)
*   G0    = 0.085 mm (rest offset outside the band; 0.07-0.10 evidence)
*   C_p   = 237 pF  (other 63 reeds + wiring + strays, estimated)
*   V_pol = 147 V   (service-manual polarizing voltage)
*
* Pins:
*   plate      - pickup plate node (AC-only; connect R-1 22K from here
*                to the preamp 'in' pin)
*   reed_disp  - reed tip displacement at the pickup, mm as volts
*                (positive = hammer direction, upward). C4 ff is about
*                1.19 mm in the plugin (tables::pickup_swing_mm, provisional).
*
* Instance params:
*   sec   - keyboard section: 1 bass (reeds 1-20), 2 middle (21-42),
*           3 treble (43-64). Default 2 (A4 = reed 37).
*   sign  - +1 where the band is above the reed (bass), -1 below (treble
*           and middle). Default -1.
*   gnd        - ground reference (the reed / AC ground)
*
* Usage:
*   Xpickup plate reed_disp 0 wurli_pickup sec=2 sign=-1
*   R1      plate preamp_in 22K
*   Xpre    preamp_in out vcc 0 fb_junct wurli_preamp
*
* NOTE: works in .op, .ac (linearization about rest) and .tran.

.include pickup_law.inc

.SUBCKT wurli_pickup plate reed_disp gnd params: sec=2 sign=-1

.param C_0   = 3P
.param C_p   = 237P
.param V_pol = 147
.param G0    = 0.085

* ============================================================
* Variable capacitor: charge-based current source
* ============================================================
* Physics: i = d/dt[ C(u) * (V_pol + V(plate)) ], drawn from the
* plate node to gnd (at DC the derivative is zero: no DC current).
*
* Realization: the charge Q is computed as a voltage on qnode, scaled
* by C_ref (V(qnode) = Q / C_ref), and differentiated by a REAL
* capacitor C_ref; F_reed mirrors that capacitor's current (= dQ/dt)
* out of the plate node. (qnode idles at C_0*V_pol/C_ref = 441 V; it is
* an internal bookkeeping node, not a circuit voltage.) This is mathematically identical to
*   B_reed plate gnd I = ddt(C(u) * ({V_pol} + V(plate)))
* but the derivative goes through the simulator's own integration
* and truncation-error control. The direct ddt() form was tried and
* rejected (2026-09-22): in tb_full_chain at 3520 Hz, y = 0.10 it
* threw a one-step numerical kick of the plate from 0.03 V to 13.9 V
* at t = 140.2 ms (with tmax = 1 us), and ngspice does not linearize
* B-source ddt() in .ac at all (the pickup contributed exactly zero).
* This form is clean in .tran and linearizes correctly in .ac.
.param C_ref = 1P
* law(u) selected per section; the rest value keeps C = C_0 at rest.
B_law   lawn   gnd  V = {sec} == 1 ? pickup_law_bass({sign}*V(reed_disp) - {G0}) - pickup_law_bass(-{G0})
+                     : {sec} == 2 ? pickup_law_middle({sign}*V(reed_disp) - {G0}) - pickup_law_middle(-{G0})
+                     : pickup_law_treble({sign}*V(reed_disp) - {G0}) - pickup_law_treble(-{G0})
B_q     qnode  gnd  V = ({C_0}/{C_ref}) * (1 + V(lawn)) * ({V_pol} + V(plate))
V_qsns  qnode  qcap DC 0
C_q     qcap   gnd  {C_ref}
F_reed  plate  gnd  V_qsns 1

* ============================================================
* Parasitic capacitance
* ============================================================
* All other 63 reeds (at rest), wiring strays, PCB pads.
* C_total = C_0 + C_p = 240 pF at rest.
C_parasitic  plate  gnd  {C_p}

.ENDS wurli_pickup
