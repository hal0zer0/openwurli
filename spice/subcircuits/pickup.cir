* Wurlitzer 200A Electrostatic Pickup Model (current-source interface)
* ===================================================================
* Behavioral model of the variable-capacitance reed pickup, reduced to
* what the pickup physically is: a displacement-modulated capacitor on
* the plate node. It contains NO feed resistor and NO coupling cap.
*
* ---------------------------------------------------------------------
* REVISION 2026-09-22 (external circuit review): this subcircuit was
* pre-revision. It carried R_feed (1MEG vhv->plate) and C_coupling
* (0.022uF plate->sig_out), and quoted a 2312 Hz corner from a
* "R-2 2M to Vcc / R-3 470K to ground" input network. The 2026-09-13
* drawn-topology revision moved the input network INTO
* subcircuits/preamp.cir, which now owns R-2 (1MEG, the +150V
* polarizing rail treated as AC ground) and C-1 (0.022uF). Keeping them
* here as well instantiated both parts TWICE in every chain bench.
* Superseded, do not re-introduce: the 2312 Hz corner, the 287K
* R_feed||R_input network, R_feed/C_coupling in this subcircuit.
* ---------------------------------------------------------------------
*
* Revised topology (schematic #203720-S-3, docs/research/preamp-circuit.md
* §2.3):
*
*   +150V line -> R-2 (1M) -> R-1/C-1 junction -> R-1 (22K) -> plate
*
*   plate --[R-1 22K, external]-- preamp 'in' pin
*                                   |-- R-2 1MEG to AC ground  } inside
*                                   `-- C-1 0.022uF -> base1   } preamp.cir
*                                                 (C-2 220pF, R-3 470K ...)
*
* Why the polarizing voltage is an internal parameter:
*   A capacitive pickup draws no DC current, so there is no DC drop
*   across R-2 or R-1 and the plate sits at the full polarizing voltage.
*   The pickup's physics only needs that total bias V_pol; the signal
*   is the AC deviation V(plate) about it. Modelling the +150V rail as
*   AC ground (as preamp.cir's R2-to-gnd does) is then exactly right,
*   and V(plate) in this deck is an AC-only node at 0 V DC.
*
* Physics:
*   Each reed is a grounded steel tine vibrating near the plate.
*   Reed-plate capacitance vs normalized displacement y = x/d_0
*   (0 = rest, positive = toward plate, y < 1):
*     C(y) = C_0 / (1 - y)
*   Charge on that capacitance, with total plate voltage V_pol + V(plate):
*     Q = C(y) * (V_pol + V(plate))
*   The pickup draws i = dQ/dt from the plate node. With the plate
*   deviation small against V_pol, the drive is a current
*     i ~= V_pol * dC/dt  (proportional to j*omega*y)
*   plus the C(y)*dV(plate)/dt term that makes the reed part of the
*   plate capacitance. The 1/(1-y) law is the primary H2 ("bark")
*   source: H2/H1 ~= y * C_p / (2*(C_0+C_p)) under constant charge.
*
* Frequency response (set by the LOAD, not by this subcircuit):
*   C_total = C_0 + C_p = 240 pF (LOW confidence, pickup-system.md §3.6)
*   works against R-1 into the preamp input network (R-2 1M, C-1, C-2
*   220pF in parallel at audio, R-3 470K). Under the physical j*omega
*   drive the plate->R-1->preamp response is a high-pass with its
*   in-band corner at ~880-900 Hz (C-2 grounded). It is NOT one-pole:
*   the network is second-order-with-zero. Fit to the measured response,
*   not to a corner frequency. See docs/research/pickup-system.md §3.7.
*
* Key parameters:
*   C_0   = 3 pF    (per-reed capacitance at rest, estimated)
*   C_p   = 237 pF  (other 63 reeds + wiring + strays, estimated)
*   V_pol = 147 V   (service-manual polarizing voltage)
*
* Pins:
*   plate      - pickup plate node (AC-only; connect R-1 22K from here
*                to the preamp 'in' pin)
*   reed_disp  - normalized reed displacement y (unitless, |y| < 0.5)
*   gnd        - ground reference (the reed / AC ground)
*
* Usage:
*   Xpickup plate reed_disp 0 wurli_pickup
*   R1      plate preamp_in 22K
*   Xpre    preamp_in out vcc 0 fb_junct wurli_preamp
*
* NOTE: works in .op, .ac (exact linearization about y = 0) and .tran.

.SUBCKT wurli_pickup plate reed_disp gnd

.param C_0   = 3P
.param C_p   = 237P
.param V_pol = 147

* ============================================================
* Variable capacitor: charge-based current source
* ============================================================
* Physics: i = d/dt[ C_0/(1-y) * (V_pol + V(plate)) ], drawn from the
* plate node to gnd (at DC the derivative is zero: no DC current).
*
* Realization: the charge Q is computed as a voltage on qnode, scaled
* by C_ref (V(qnode) = Q / C_ref), and differentiated by a REAL
* capacitor C_ref; F_reed mirrors that capacitor's current (= dQ/dt)
* out of the plate node. (qnode idles at C_0*V_pol/C_ref = 441 V; it is
* an internal bookkeeping node, not a circuit voltage.) This is mathematically identical to
*   B_reed plate gnd I = ddt({C_0}/(1-V(reed_disp)) * ({V_pol} + V(plate)))
* but the derivative goes through the simulator's own integration
* and truncation-error control. The direct ddt() form was tried and
* rejected (2026-09-22): in tb_full_chain at 3520 Hz, y = 0.10 it
* threw a one-step numerical kick of the plate from 0.03 V to 13.9 V
* at t = 140.2 ms (with tmax = 1 us), and ngspice does not linearize
* B-source ddt() in .ac at all (the pickup contributed exactly zero).
* This form is clean in .tran and linearizes correctly in .ac.
.param C_ref = 1P
B_q     qnode  gnd  V = ({C_0}/{C_ref}) / (1 - V(reed_disp)) * ({V_pol} + V(plate))
V_qsns  qnode  qcap DC 0
C_q     qcap   gnd  {C_ref}
F_reed  plate  gnd  V_qsns 1

* ============================================================
* Parasitic capacitance
* ============================================================
* All other 63 reeds (at rest), wiring strays, PCB pads.
* C_total = C_0 + C_p = 240 pF at rest.
C_parasitic  plate  gnd  {C_p}

.ENDS wurli_pickup
