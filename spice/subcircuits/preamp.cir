* Wurlitzer 200A Reed-Bar Preamp Subcircuit
* ===========================================
* Two-stage direct-coupled NPN CE amplifier (TR-1, TR-2)
* with series-series emitter feedback through R-10/Ce1 and
* Miller feedback caps C-3, C-4.
*
* ============================================================================
* TOPOLOGY REVISION 2026-09-13 (drawn topology, cross-verified)
* Pixel-level instrumented re-reads of schematic #203720-S-3, both
* circulating scan surfaces; independently confirmed by SPICE, by hand
* derivation, and by the GroupDIY real-instrument DC measurement set.
* Superseded readings (kept here so nobody re-introduces them):
*   - "R-2 = 2MEG from Vcc to base1" - WRONG. R-2 is 1MEG from the +150V
*     polarizing line to the R-1/C-1 junction, pickup side of the input
*     cap. There is NO resistor from TR-1's base to Vcc. The 2MEG was
*     fitted to the misread topology; the 380K "measured" input impedance
*     that justified it was circular (it IS 2M||470K arithmetic).
*   - "R-3 = 470K to ground" - WRONG. R-3 returns from base1 to the
*     R-7/R-8 junction: DC feedback from TR-2's emitter divider, and
*     TR-1's ONLY DC bias path. Reproduces the printed base 2.45V and
*     hardware 2.447V that the divider topology missed by 0.35V.
*   - "Ce2 bypasses R-7 only (Av2 = -2.2)" - WRONG. C-7 spans TR-2
*     emitter -> ground (across R-7+R-8). Stage 2 is high-gain CE
*     (A1~8 / A2~120-140 at 1 kHz, independently measured); closed-loop gain
*     is set by the R-10/Ce1 feedback divider.
*   - Output DC-coupled through R-9 - WRONG. C-6 (4.7uF) couples the
*     collector to the R-9/R-10 node, which sits at 0V DC.
*   - "C20 220pF is 206A-only" - designator conflation. The base1 220pF
*     is C-2, a real 200A part (C-2 and C20 are different 220pF parts). Its
*     bottom rail is drawn broken on both surfaces (drawing defect);
*     ground return is the settled assumption (emitter return would move
*     the pickup corner 850 -> 1375 Hz).
*   - Vcc 15V - the service manual TEXT specifies "+14.5 volts regulated"
*     (p.64); the drawing marks "+15V". 14.5 closes the TR-2 collector
*     KCL imbalance in the drawing's own marks. Supply belongs to the
*     testbench; use 14.5V.
* Verified figures on this topology (Vcc 14.5, 2N5089 card, TR-2 BF 400):
*   TR-1 B 2.489-2.651 / hardware 2.447; closed-loop ~14 dB at
*   R_shunt ~18-19K (node_c6); pickup-side corner ~900 Hz (C-2 grounded);
*   preamp-only HF -3dB ~16.7 kHz.
* ============================================================================
*
* Pins:
*   in      - signal input = the R-1/C-1 junction (R-1 22K is EXTERNAL,
*             between pickup plate and this pin)
*   out     - signal output (after R-9, 6.8K series)
*   vcc     - +14.5V supply
*   gnd     - ground reference
*   fb_junct - feedback junction (connect LDR path here)
*              For no tremolo: connect the divider floor (~13K) to gnd
*              For tremolo: connect LDR/divider path to gnd

.SUBCKT wurli_preamp in out vcc gnd fb_junct

* --- R-2: polarizing feed, 1MEG (drawn value, glyph-verified) ---
* Physically +150V -> R-2 -> this node; the +150V rail is AC ground.
* The DC polarizing path itself lives on the pickup side.
R2    in    gnd    1MEG

* --- Input coupling capacitor ---
* .022 uF blocks the polarizing DC from the base; passes audio.
Cin   in    base1  0.022U

* --- C-2: 220pF at base1 (real 200A part; grounded return assumed) ---
C2    base1 gnd    220P

* --- D-1: reverse-biased protection diode ---
D1    gnd   base1  D1N4148

* --- Stage 1: TR-1 (NPN common-emitter) ---
* Rc1 = 150K collector load
* Re1 = 33K DC emitter path to ground
* Ce1 = 4.7uF couples emitter to feedback junction (NOT to ground!)
* C-3 = 100pF collector-base Miller feedback cap
Q1    coll1 base1 emit1  Q2N5089
Rc1   vcc   coll1  150K
Re1   emit1 gnd    33K
Ce1   emit1 fb_junct 4.7U
Cc3   coll1 base1  100P

* --- Direct coupling: TR-1 collector = TR-2 base ---
* (coll1 node serves as both TR-1 collector and TR-2 base)

* --- Stage 2: TR-2 (NPN common-emitter) ---
* Rc2 = 1.8K collector load
* Re2a (R-7) = 270 ohm + Re2b (R-8) = 820 ohm; Ce2 (C-7) = 22uF spans
* BOTH (emitter -> ground): high-gain CE stage, emitter AC-grounded.
* C-4 = 100pF collector-base Miller feedback cap
Q2    coll2 coll1 emit2a  Q2N5089
Rc2   vcc   coll2  1.8K
Re2a  emit2a emit2b  270
Ce2   emit2a gnd  22U
Re2b  emit2b gnd    820
Cc4   coll2  coll1  100P

* --- R-3: TR-1 DC bias via feedback from TR-2's emitter divider ---
* base1 -> R-7/R-8 junction. Negative DC servo (loop gain ~2.1,
* desensitivity ~3.1); at audio the junction is AC ground via Ce2,
* so R-3 presents 470K to AC ground at the base.
R3    base1 emit2b 470K

* --- Output: C-6 couples the collector to the R-9/R-10 node ---
* node_c6 sits at 0V DC; R-9 is outside the feedback loop.
C6    coll2   node_c6  4.7U
R9    node_c6 out      6.8K

* --- Global AC negative feedback (series-series / emitter) ---
* R-10 (56K) from node_c6 to fb_junct; Ce1 AC-couples fb_junct to TR-1's
* emitter. The LDR/divider path (external) shunts fb_junct to ground,
* modulating how much feedback reaches the emitter and thus the gain.
R10   node_c6 fb_junct  56K

.ENDS wurli_preamp
