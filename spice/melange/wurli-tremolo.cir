* Wurlitzer 200A Tremolo Oscillator
* Twin-T oscillator (TR-3/TR-4) driving the LG-1 LED, ~5.5-5.9 Hz.
*
* ============================================================================
* TOPOLOGY REVISION 2026-09-13 (drawn LED path, arbiter-verified)
* Schemer pixel-instrumented reads of #203720-S-3 (robogogo t352/375):
* R-18 (680) is in the LED DRIVE PATH, not the LDR leg (the old reading
* misread two line hops as junctions). The shared collector load is the
* series chain: +V -> R-18 -> LG-1 pin 2 (LED anode) -> pin 1 (cathode)
* -> R-17 -> collector node. The LDR leg (cable pin 5 -> LG-1 pin 4,
* pin 3 -> ground) has NO series resistor and lives in the preamp deck
* as R_ldr.
*   R-17 (4.7K, part 203717-2) is a wiper-strapped VIBRATO ADJUST depth
*   TRIMMER (manual PCB layout; arrowhead on the archive scan). Its value
*   below is ONE position; the final default is a Phase-3 calibration
*   decision. Untuned corroboration: at BF 155 + R-17=0 + 14.5V the deck
*   reproduces the print's "TYPICAL WAVE FORM" marks (11.5 Vpp, ~5.9V
*   mean, ~5.85 Hz) with zero fitted parameters (t373 real-card grid).
*   Trimmer loads the oscillator: rate moves ~+3.6% at R-17=0.
*   V1: 14.5V (manual text p.64; drawing marks "+15V").
* TRANSISTOR CARD: BF=155 = GE 1971 DC typical for the Yellow-grade
* 2N292x (TR-3/4 = 142083-2; grade reading rule-of-thumb-strong, memory:
* voltron-schematic-challenge-2026-09). Band 150-300 (small-signal);
* sensitivity edges 100/300 measured in the t373 grid.
* LED CARD: single-diode level fit to TI TIL209A Fig 4 (June 1973), the
* only period sub-mA I-V curve; residual <=5.6 mV over 0.35-20 mA
* (melange-circuits fit, KCL-verified to 0.14 mV; digitisation: schemer
* benchmarks/voltron_reads/led_iv/). The TI curve is DRAFTED artwork -
* use as a LEVEL, do not read device physics from IS/N. Bounds cards
* (HP-derived LOWa/LOWb) differ by <=16% in I_min, ~2% mean/peak: card
* choice is second-order. No period data exists below 0.1 mA. NOT in
* this deck: the light law (current -> light -> R_cell lives in Rust),
* temperature (-0.55..-0.85 %/degC light; ~-16%/20degC warm-up), and the
* 5:1 LED-to-LED light spread.
* ============================================================================
*
* The twin-T notch filter in TR-3's feedback path sets the oscillation
* frequency. Non-standard ratios (R_shunt/R_series = 0.04) produce a
* shallow notch for easy startup, with ~3-10% THD.
*
* Deliverable for the plugin: LED CURRENT (through D_LED), which the Rust
* Tremolo module maps through the light law to the preamp deck's R_ldr.

* --- Twin-T feedback network ---
* Highpass T: out --[C17]-- node_hp --[C16]-- base3, R12 to GND
C17   out    node_hp  0.12U
C16   node_hp  base3    0.12U
R12   node_hp  0        27K

* Lowpass T: out --[R14]-- node_lp --[R13]-- base3, C18 to GND
R14   out    node_lp  680K
R13   node_lp  base3    680K
C18   node_lp  0        0.12U

* --- TR-3: Oscillator amplifier ---
Q3    out   base3  emit3  Q2N2924
R15   base3   0     680K

* --- Emitter / TR-4 base junction ---
R16   emit3   0     10K

* --- TR-4: LED driver buffer ---
Q4    out   emit3  0     Q2N2924

* --- Shared collector load: the drawn LED path ---
* +14.5V -> R-18 680 -> LED (anode->cathode) -> R-17 trimmer -> collector.
* R-17 = 4.7K is the trimmer's FULL value (weakest LED drive, closest to
* the previously shipped weak-drive character); position is a Phase-3
* calibration output - print-typical condition is R-17 near 0 (max depth).
R18   vcc   leda   680
D_LED leda  ledk   LED_GAASP
R17   ledk  out    4.7K

* --- Stray cap on output (prevent trapezoidal oscillation) ---
Cpar  out   0      1P

* --- Supply: +14.5V (manual text; drawing mark "+15V" - see header) ---
V1    vcc   0      DC 14.5

* --- Self-oscillating: high input impedance to avoid loading output ---
.input_impedance 10MEG

* --- Device models ---
* Q2N2924: BF 155 = GE 1971 documented DC typical (Yellow grade).
.model Q2N2924 NPN(IS=1.4e-14 BF=155)
* LED_GAASP: TI TIL209A level fit (see header; level, not physics).
.model LED_GAASP D(IS=2.2324e-29 N=1.00 RS=0)
