* Wurlitzer 200A Tremolo Oscillator
* Twin-T oscillator (TR-3/TR-4 = 2N2924), ~5.3 Hz.
* Flattened from openwurli/spice/subcircuits/tremolo_osc.cir.
*
* The twin-T notch filter in TR-3's feedback path sets the oscillation
* frequency. Non-standard ratios (R_shunt/R_series = 0.04) produce a
* shallow notch for easy startup, with ~3-10% THD.
*
* Output at led_out swings 11.5 Vpp (near rail-to-rail).
* In the real circuit this drives an LED; here it's just a voltage output.

* --- Twin-T feedback network ---
* Highpass T: led_out --[C17]-- node_hp --[C16]-- base3, R12 to GND
C17   out    node_hp  0.12U
C16   node_hp  base3    0.12U
R12   node_hp  0        27K

* Lowpass T: led_out --[R14]-- node_lp --[R13]-- base3, C18 to GND
R14   out    node_lp  680K
R13   node_lp  base3    680K
C18   node_lp  0        0.12U

* --- TR-3: Oscillator amplifier ---
Q3    out   base3  emit3  Q2N2924
R15   base3   0     680K

* --- Emitter / TR-4 base junction ---
R16   emit3   0     10K

* --- TR-4: LED driver buffer ---
Q4    out   emit3  0     Q2N2924

* --- Shared collector load ---
R17   vcc   out    4.7K

* --- Stray cap on output (prevent trapezoidal oscillation) ---
Cpar  out   0      1P

* --- Supply ---
V1    vcc   0      DC 15

* --- Self-oscillating: high input impedance to avoid loading output ---
.input_impedance 10MEG

* --- Device model ---
.model Q2N2924 NPN(IS=1.4e-14 BF=200)
