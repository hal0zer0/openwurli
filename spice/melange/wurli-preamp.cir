* Wurlitzer 200A Reed-Bar Preamp
* Two-stage direct-coupled NPN CE amplifier (TR-1, TR-2 = 2N5089 card)
* with series-series emitter feedback and LDR tremolo modulation.
* Flattened from openwurli/spice/subcircuits/preamp.cir for melange codegen.
*
* ============================================================================
* TOPOLOGY REVISION 2026-09-13 (drawn topology, cross-verified)
* Pixel-level instrumented re-reads of #203720-S-3, both circulating scan
* surfaces; confirmed by an independent SPICE implementation, an independent
* hand derivation, and a real-instrument DC measurement set (GroupDIY,
* preamp-circuit.md:221). Changes vs the pre-revision deck:
*   R2: was 2MEG vcc->base1 (misread). Drawn: 1MEG from the +150V polarizing
*       line to the R-1/C-1 junction (mid_in). The +150V rail is AC ground in
*       this audio deck, so R2 = mid_in -> 0. The DC polarizing path lives on
*       the pickup side (pickup.rs / Phase-2 interface decision).
*   R3: was base1->gnd. Drawn: base1 -> R-7/R-8 junction (emit2b) = DC
*       feedback from TR-2's emitter divider. This is TR-1's ONLY DC bias
*       path (grounded-R3 leaves the base with no bias source at all).
*   C7 (Ce2): was across R-7 (270) only. Drawn: TR-2 emitter -> ground,
*       across R-7+R-8 in series. Stage 2 is a high-gain CE stage; closed-
*       loop gain is set by the R-10/C-5 global feedback.
*   C6: NEW - 4.7uF series coupling, TR-2 collector (+) -> R-9/R-10 node.
*       The R-9/R-10 node sits at 0V DC; no DC flows into R-10/R_ldr.
*   C2: RESTORED - 220pF at base1. This is C-2, a real 200A part (the
*       earlier "C20, 206A-only" removal was a designator conflation - C-2
*       and C20 are different 220pF parts; C20 is the aux-section one). Its bottom rail is drawn BROKEN on both
*       surfaces (drawing defect); ground return is the settled assumption.
*   V1: 14.5V. Service manual TEXT says "+14.5 volts regulated" (p.64); the
*       drawing marks "+15V". 14.5 closes the TR-2 collector KCL imbalance
*       implied by the drawing's own DC marks (+10.4% -> +1.6%).
* INTEGRATOR: author-pinned to backward Euler below. The deck is
* trapezoidal-unstable (spectral radius 1.1394, dominant sign -1: a
* Nyquist-marginal z=-1 mode, which L-stable BE genuinely damps — the
* auto-promoter selects BE for this deck anyway; the pin makes it
* deterministic across regens). BE's HF damping understates the ~16.7 kHz
* corner at low sim rates; the generated solver runs oversampled, and the
* shipping hand solver treats stability separately. Trap-pinned
* small-signal analysis of this deck is faithful (cross-checked to 2.5%)
* — the instability is a transient-integration property.
* TRANSISTOR CARD: 2N5089 retained pending the Phase-3 voicing decision.
* The original part is Green-grade 2N292x (ss-hfe 235-470, DC typ 215; GE
* 1971 pp.498-500 - 2N2923/24/25 are the color grades of the 2N2926
* population). Hardware-anchored TR-1 hFE = 350+/-50; sim best-fit TR-2
* BF ~350-400. Carry BF as a BAND, never a fitted point (beta2 is not
* extractable from the available anchors).
* ============================================================================
*
* N=11 nodes: in, mid_in, base1, emit1, coll1, emit2a, emit2b, coll2,
*             node_c6, out, fb
* M=5 nonlinear dimensions: 2 BJTs (2D each) + 1 diode (1D)

* --- Input coupling: R1 (22K) in series with Cin (0.022uF) ---
* R1 is external to the original subcircuit (between pickup and preamp input).
* mid_in is the R-1 / C-1 junction - the node the +150V polarizing feed
* (R2) lands on, per the drawn topology.
R1    in     mid_in  22K
Cpar  in     0       1P
Cin   mid_in base1   0.022U

* --- R2: polarizing feed, 1MEG (drawn value, glyph-verified) ---
* Physically: +150V line -> R2 -> mid_in. +150V is AC ground here.
R2    mid_in 0      1MEG

* --- C-2: 220pF at base1 (real 200A part; return = ground, see header) ---
C2    base1  0      220P

* --- Protection diode (reverse-biased under normal operation) ---
D1    0     base1  D1N4148

* --- Stage 1: TR-1 (NPN common-emitter) ---
Q1    coll1 base1 emit1  Q2N5089
Rc1   vcc   coll1  150K
Re1   emit1 0      33K
Ce1   emit1 fb     4.7U
Cc3   coll1 base1  100P

* --- Stage 2: TR-2 (NPN common-emitter) ---
* Direct-coupled: TR-1 collector = TR-2 base (coll1 node)
* Ce2 (C-7) AC-grounds the emitter across BOTH emitter resistors:
* stage 2 is a high-gain CE stage (open-loop A2 ~ 120-140 at 1 kHz,
* zero ~6.6 Hz / pole ~1 kHz from the incomplete bypass at low f).
Q2    coll2 coll1 emit2a  Q2N5089
Rc2   vcc   coll2  1.8K
Re2a  emit2a emit2b  270
Ce2   emit2a 0     22U
Re2b  emit2b 0    820
Cc4   coll2  coll1  100P

* --- R3: TR-1 DC bias via feedback from TR-2's emitter divider ---
* base1 -> R-7/R-8 junction. Negative DC servo, loop gain ~2.1,
* desensitivity ~3.1. Reproduces the printed TR-1 base 2.45V and the
* GroupDIY hardware 2.447V that the old divider topology missed by 0.35V.
R3    base1 emit2b 470K

* --- Output: C-6 couples the collector to the R-9/R-10 node ---
* node_c6 sits at 0V DC. R-9 is OUTSIDE the feedback loop (pure output
* series loss); R-10 taps node_c6, i.e. feedback is taken at the collector.
C6    coll2  node_c6  4.7U
R9    node_c6 out    6.8K

* --- Global AC negative feedback (series-series / emitter) ---
* R10 from node_c6 to fb_junct; Ce1 AC-couples fb_junct to TR-1 emitter.
* LDR shunts fb_junct to ground, modulating feedback and thus gain.
R10   node_c6  fb     56K

* --- Tremolo LDR (plugin-driven audio-rate resistor) ---
* Declared as .runtime R (not .pot) because the LDR resistance is driven
* by the Tremolo module's envelope, not a user-facing knob. Semantics
* are identical to .pot R after melange's 2026-04-20 reseed strip.
R_ldr fb    0      100k
.runtime R_ldr 1k 1Meg as r_ldr

* --- Integrator: author-pinned (see header) ---
.integrator be

* --- Supply: +14.5V (manual text; drawing mark "+15V" - see header) ---
V1    vcc   0      DC 14.5

* --- Device models ---
* 2N5089: full Gummel-Poon. Source: LTspice standard.bjt / ON Semi 2N5089 datasheet.
* Mirrored in spice/models/transistors.lib and all spice/testbench/*.cir — this is the
* same model the ngspice testbenches validate against.
.model Q2N5089 NPN(IS=3.03E-14 BF=1434 NF=1.005 VAF=98.5 IKF=0.01358
+  ISE=2.88E-15 NE=1.262 BR=4.62 NR=1 VAR=22 IKR=0.1 ISC=1.065E-11
+  NC=1.41 RB=57 RE=0.518 RC=2.58 CJE=3.22E-12 VJE=0.65 MJE=0.33
+  TF=5.4E-10 CJC=1.35E-12 VJC=0.4 MJC=0.33 XCJC=0.63 TR=5E-08
+  XTB=1.38 EG=1.11 XTI=3 FC=0.5)
.model D1N4148 D(IS=2.52e-9 N=1.752)
